# Ansys Electronics Desktop project, version 2021.2
materials:
  vacuum: permittivity=1
  air: permittivity=1.0006 permeability=1.0000004
  steel_3413: permeability{BTypeForSingleCurve=intrinsic HUnit=A_per_meter BUnit=tesla curve (0, 0) (81, 0.6) (110, 0.7) (130, 0.8) (152, 0.9) (182, 1) (213, 1.1) (243, 1.2) (275, 1.3) (320, 1.4) (390, 1.5) (520, 1.6) (800, 1.7) (1040, 1.75) (1500, 1.8) (2366, 1.85) (3825, 1.9) (7000, 1.95) (16000, 2) (30000, 2.03) (50000, 2.05) (100000, 2.1) (150000, 2.14) (200000, 2.175) (250000, 2.19) (300000, 2.195) (350000, 2.196) (400000, 2.197) (450000, 2.198) (500000, 2.1985)} conductivity=2000000 magnetostriction{PropertyModelType=0 Dir1ModelType=0 Dir2ModelType=0 IsoCoeff=0 IsoHMax=0A_per_meter IsoHMin=0A_per_meter Dir1Coeff=0 Dir1HMax=0A_per_meter Dir1HMin=0A_per_meter Dir1VecX=1 Dir1VecY=0 Dir1VecZ=0 Dir2Coeff=0 Dir2HMax=0A_per_meter Dir2HMin=0A_per_meter Magnetostriction{Isotropic{OneVariation{DatasetMapsName="Lambda-H curves versus Stress"}} Direction1{OneVariation{DatasetMapsName="Lambda-H curves versus Stress"}} Direction2{OneVariation{DatasetMapsName="Lambda-H curves versus Stress"}} SelectedDatasetMapsName="Lambda-H curves versus Stress"}}
  steel_1008: permeability{HUnit=A_per_meter BUnit=tesla curve (0, 0) (159.2, 0.2402) (318.3, 0.8654) (477.5, 1.1106) (636.6, 1.2458) (795.8, 1.331) (1591.5, 1.5) (3183.1, 1.6) (4774.6, 1.683) (6366.2, 1.741) (7957.7, 1.78) (15915.5, 1.905) (31831, 2.025) (47746.5, 2.085) (63662, 2.13) (79577.5, 2.165) (159155, 2.28) (318310, 2.485) (397887, 2.5851)} conductivity=2000000
  steel_stainless: conductivity=1100000
  copper: permeability=0.999991 conductivity=58000000

design Maxwell2DDesign1 (Maxwell 2D, Magnetostatic, XY geometry, model units mm)
variables:
  stator_height = 50mm
  normalized_stator_height = 1meter
  number_of_rotor_teeth = 8
  number_of_stator_teeth = 6
  rotor_rotation_angle = 360 / number_of_rotor_teeth deg
  stator_rotation_angle = 360 / number_of_stator_teeth deg
  rotation_phase = 90deg
  current_density = 25000000A_per_m2
geometry:
  case [steel_stainless] = imported_body(D:/ProgramData/Ansys/Temp/427A2034416468545212..sm3)
  stator [steel_3413] = imported_body(D:/ProgramData/Ansys/Temp/427A2034416468545212..sm3)
  0_3 = imported_body(D:/ProgramData/Ansys/Temp/427A2034416468545212..sm3)
  rotor [steel_3413] = imported_body(D:/ProgramData/Ansys/Temp/427A2034416468545212..sm3)
  phase_a_plus = imported_body(D:/ProgramData/Ansys/Temp/427A2034416468545212..sm3)
  [case, stator, 0_3, rotor, phase_a_plus].move(-0.37820398mm, 0.18910199mm, 0mm)
  0_2_1 = stator.copy()
  case.subtract(0_2_1)
  0_5_1 = phase_a_plus.copy()
  stator.subtract(0_5_1)
  Circle5 = circle(normal=Z, centre=(0mm, 0mm, 0mm), radius=45mm)
  phase_a_plus.subtract(Circle5)
  phase_c_plus_1, phase_b_minus_2 [copper] = phase_a_plus.separate_bodies()
  phase_a_plus.delete()
  rotor.subtract(0_3)
  phase_c_plus_2 [copper] = phase_b_minus_2.split(plane=ZX, keep=Both)
  phase_b_minus_1 [copper] = phase_c_plus_1.split(plane=ZX, keep=Both)
  phase_b_plus_2, phase_a_plus_2 [copper] = phase_c_plus_2.duplicate_around_axis(axis=Z, angle=60deg, total=3)
  phase_a_minus_2, phase_c_minus_2 [copper] = phase_b_minus_2.duplicate_around_axis(axis=Z, angle=60deg, total=3)
  phase_a_minus_1, phase_c_minus_1 [copper] = phase_b_minus_1.duplicate_around_axis(axis=Z, angle=60deg, total=3)
  phase_b_plus_1, phase_a_plus_1 [copper] = phase_c_plus_1.duplicate_around_axis(axis=Z, angle=60deg, total=3)
  bound [air] = circle(normal=Z, centre=(0mm, 0mm, 0mm), radius=100mm)
  rotor.rotate(axis=Z, angle=rotation_phase / number_of_rotor_teeth)
  group Rotor_1 = rotor
  group Stator_1 = stator
  group PhaseA_Minus = phase_a_minus_2, phase_a_minus_1
  group PhaseA_Plus = phase_a_plus_2, phase_a_plus_1
  group PhaseB_Plus = phase_b_plus_2, phase_b_plus_1
  group PhaseB_Minus = phase_b_minus_2, phase_b_minus_1
  group PhaseC_Plus = phase_c_plus_1, phase_c_plus_2
  group PhaseC_Minus = phase_c_minus_2, phase_c_minus_1
  group Air = bound
  group Case_1 = case
boundaries and excitations:
  zero_vector_potential: Vector Potential Edges=bound.edge(1 of 1) Value=0
  current_density_a_minus_1: Current Density Objects=phase_a_minus_1 Value="-current_density / 3"
  current_density_a_minus_2: Current Density Objects=phase_a_minus_2 Value="-current_density / 3"
  current_density_a_plus_1: Current Density Objects=phase_a_plus_2 Value="current_density / 3"
  current_density_a_plus_2: Current Density Objects=phase_a_plus_1 Value="current_density / 3"
  current_density_b_plus_1: Current Density Objects=phase_b_plus_1 Value=0
  current_density_b_plus_2: Current Density Objects=phase_b_plus_2 Value=0
  current_density_b_minus_1: Current Density Objects=phase_b_minus_1 Value=0
  current_density_b_minus_2: Current Density Objects=phase_b_minus_2 Value=0
  current_density_c_plus_1: Current Density Objects=phase_c_plus_1 Value=0
  current_density_c_plus_2: Current Density Objects=phase_c_plus_2 Value=0
  current_density_c_minus_1: Current Density Objects=phase_c_minus_2 Value=0
  current_density_c_minus_2: Current Density Objects=phase_c_minus_1 Value=0
parameters:
  torque: Torque Coordinate_System=Global Is_Positive=false Objects=rotor
mesh:
  length: LengthBased Edges=?.edge(#8, #9, #15, #16, #29, #30, #31, #32, #33, #34, #35, #36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) case.edge(at (-68, 0, 0)) stator.edge(at (55.447, 21.0147, 0), at (60, 0, 0), at (55.447, -21.0147, 0), at (48.1849, -17.6582, 0), at (38.9711, -22.5, 0), at (39.3849, -32.9002, 0), at (45.9228, -37.5112, 0), at (30, -51.9615, 0), at (9.52423, -58.5259, 0), at (8.8, -50.5584, 0), at (0, -45, 0), at (-8.8, -50.5584, 0)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) phase_a_plus.edge(#665, #668) rotor.edge(#692) phase_b_minus_2.edge(at (-52.5, 0, 0)) phase_c_plus_2.edge(all 5) phase_c_plus_1.edge(at (52.5, 0, 0)) phase_b_minus_1.edge(all 5) phase_b_plus_2.edge(all 5) phase_a_plus_2.edge(all 5) phase_a_minus_2.edge(all 5) phase_c_minus_2.edge(all 5) phase_a_minus_1.edge(all 5) phase_c_minus_1.edge(all 5) phase_b_plus_1.edge(all 5) phase_a_plus_1.edge(all 5) bound.edge(1 of 1) MaxLength=1mm
  initial mesh: GlobalSurfApproximation{CurvedSurfaceApproxChoice=ManualSettings SurfDev=0.1mm NormalDev=1deg AspectRatio=1} GlobalModelRes{DefeatureLength=0.1mm} MeshMethod=AnsoftTAU
setups:
  setup: Magnetostatic MaximumPasses=5 MinimumPasses=5 MinimumConvergedPasses=1 PercentRefinement=10 PercentError=0.1 SolveMatrixAtLast=false NonLinearResidual=0.0001 SmoothBHCurve
optimetrics:
  ParametricSetup1: Parametric Sim._Setups=[setup]
    sweep rotation_phase: LIN 0deg 360deg 5deg
    calculate rotor_torque on setup : LastAdaptive
  ParametricSetup2: Parametric Sim._Setups=[setup]
    sweep current_density: LIN 0A_per_m2 120000000A_per_m2 5000000A_per_m2
    calculate rotor_torque on setup : LastAdaptive
output variables:
  rotor_torque = (torque.Torque / normalized_stator_height) * stator_height NewtonMeter
field plots:
  Flux_Lines1: A over case, stator, rotor, phase_c_plus_1, phase_b_minus_2, phase_c_plus_2, phase_b_minus_1, phase_b_plus_2, phase_a_plus_2, phase_a_minus_2, phase_c_minus_2, phase_a_minus_1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 on setup : LastAdaptive
  B_Vector1, Mag_B1: B over case, stator, rotor, phase_c_plus_1, phase_b_minus_2, phase_c_plus_2, phase_b_minus_1, phase_b_plus_2, phase_a_plus_2, phase_a_minus_2, phase_c_minus_2, phase_a_minus_1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 on setup : LastAdaptive
  Mesh1: MeshPlots over case, stator, rotor, phase_c_plus_1, phase_b_minus_2, phase_c_plus_2, phase_b_minus_1, phase_b_plus_2, phase_a_plus_2, phase_a_minus_2, phase_c_minus_2, phase_a_minus_1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 on setup : LastAdaptive
  A_Vector1: A over case, stator, rotor, phase_c_plus_1, phase_b_minus_2, phase_c_plus_2, phase_b_minus_1, phase_b_plus_2, phase_a_plus_2, phase_a_minus_2, phase_c_minus_2, phase_a_minus_1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 on setup : LastAdaptive
  Jz1: J over case, stator, rotor, phase_c_plus_1, phase_b_minus_2, phase_c_plus_2, phase_b_minus_1, phase_b_plus_2, phase_a_plus_2, phase_a_minus_2, phase_c_minus_2, phase_a_minus_1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 on setup : LastAdaptive
